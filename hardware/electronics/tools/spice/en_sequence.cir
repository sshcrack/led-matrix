* Power-up / panel-enable sequence (behavioral).  Checks that the panel bucks stay off until the
* Pi drives GPIO26 (JP601 1-2), turn on quickly once it does, turn off when it stops, and that the
* always-on shunt (JP601 2-3) enables them only after +5V_AUX is up.
*   24 V brick: 0 -> 24 V in 20 ms (GST160A rise time spec 50 ms max).
*   AUX buck: EN 200k/18k, hysteretic switch at 1.263 V rise / 0.913 V fall, then a 2.2 ms soft start.
*   Panel buck (LM61495) EN threshold 1.263 V rise (1.161 V min), wake 0.4 V; 2 EN pins (IEN <= 50 nA)
*   modelled as 2x 2 MOhm.  (The AUX buck also waits for the LM5069 PGD; not modelled here.)
*   BSS138 Q601/Q602: level-1 NMOS, VTO 1.3 V (datasheet 0.8..1.5 V).
.param jp=1
V24   p24 0 PWL(0 0 20m 24)
R505  p24 aen 200k
R506  aen 0   18k
Saux  p24 auxsrc aen 0 enmod
.model enmod SW(VT=1.088 VH=0.175 RON=1 ROFF=1e9)
* soft start: 5.0 V reference reached through a 2.2 ms ramp (RC approximation, tau = tSS/3)
Rsrc  auxsrc 0 1k
Baux  aux5i 0 V = min(V(auxsrc), 5.0)
Rss   aux5i aux5 733
Css   aux5  0   1u
* Pi GPIO26: Pi boot finishes at 300 ms, service stop at 700 ms (only used with JP601 1-2)
Vgpio gpio 0 PWL(0 0 300m 0 300.1m 3.3 700m 3.3 700.1m 0)
R633  gpio req 1k
* JP601: jp=1 -> pins 1-2 (GPIO26), jp=2 -> pins 2-3 (always on via R635 10k from +5V_AUX)
Rjp12 req  pon {jp==1 ? 0.01 : 1e12}
R635  aux5 force 10k
Rjp23 force pon {jp==2 ? 0.01 : 1e12}
R634  pon 0 100k
M601  kill pon 0 0 nbss
R636  aux5 kill 100k
M602  enp kill 0 0 nbss
R637  aux5 enp 47k
C632  enp 0 100n
Ren   enp 0 1Meg
.model nbss NMOS(LEVEL=1 VTO=1.3 KP=0.35 LAMBDA=0.01)
.tran 20u 900m 0 50u
.control
  alterparam jp=1
  reset
  run
  meas tran aux_on when v(aux5)=4.75 rise=1
  meas tran en_max_before max v(enp) from=0 to=299m
  meas tran en_on when v(enp)=1.263 rise=1
  meas tran en_off when v(enp)=0.913 fall=1
  let t_on = en_on - 300m
  let t_off = en_off - 700m
  echo "RESULT en_sequence jp=1-2 aux5_ready=$&aux_on en_max_before_gpio=$&en_max_before panel_on_delay=$&t_on panel_off_delay=$&t_off"
  alterparam jp=2
  reset
  run
  meas tran aux_on when v(aux5)=4.75 rise=1
  meas tran en_on when v(enp)=1.263 rise=1
  let t_on = en_on - aux_on
  echo "RESULT en_sequence jp=2-3 aux5_ready=$&aux_on panel_on_after_aux=$&t_on"
  quit
.endc
.end
