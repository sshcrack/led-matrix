* Divider thresholds with tolerance corners (1 % resistors, datasheet min/max thresholds).
*   Panel eFuse TPS259823L EN/UVLO from the converter output: 100k / 37.4k
*     (EN rise 1.18/1.20/1.23 V, fall 1.08/1.10/1.13 V).  Its OVP is fixed inside the part
*     (7.39/7.6/7.76 V rising) and needs no simulation.
*   Hot-swap LM5069 UVLO/OVLO string 95.3k / 9.31k / 8.45k (thresholds UVLO 2.45/2.5/2.55 V,
*     OVLO 2.4/2.5/2.6 V; 12/21/30 uA hysteresis current: sunk from UVLO while under-voltage,
*     sourced into OVLO while over-voltage).
*   Halo eFuse OVLO 147k / 37.4k (TPS259470A 1.183/1.20/1.223 V).
*   AUX buck EN 200k / 18k (TPSM63610 VEN rise 1.0/1.263/1.365 V, hysteresis 0.1/0.35/0.5 V).
* Each pass sweeps the input and measures where a pin crosses its threshold.
.param kt=1 kb=1 iuv=0 iov=0
Vin in 0 DC 0
* panel eFuse EN
R11 in  efen {100k*kt}
R13 efen 0  {37.4k*kb}
* LM5069 string: R4 top, R5 middle, R6 bottom
R4  in  uvlo {95.3k*kt}
R5  uvlo ovlo {9.31k*kb}
R6  ovlo 0   {8.45k*kb}
Iuv uvlo 0 DC {iuv}
Iov 0 ovlo DC {iov}
* halo OVLO
R611 in hov {147k*kt}
R613 hov 0  {37.4k*kb}
* AUX EN
R505 in aen {200k*kt}
R506 aen 0  {18k*kb}
.dc Vin 0 45 1m
.control
* lo: divider ratio high + min thresholds -> lowest trip voltages; hi: the opposite.
* pass a: UVLO hysteresis sink on (rising UV); pass b: no hysteresis currents; pass c: OVLO source on
  alterparam kt=0.99
  alterparam kb=1.01
  alterparam iuv=12u
  alterparam iov=0
  reset
  run
  meas dc hsuvr when v(uvlo)=2.45 rise=1
  set s_hsuvr = $&hsuvr
  alterparam iuv=0
  reset
  run
  meas dc uvr when v(efen)=1.18 rise=1
  set s_uvr = $&uvr
  meas dc uvf when v(efen)=1.08 rise=1
  set s_uvf = $&uvf
  meas dc hsuvf when v(uvlo)=2.45 rise=1
  set s_hsuvf = $&hsuvf
  meas dc hsovr when v(ovlo)=2.4 rise=1
  set s_hsovr = $&hsovr
  meas dc hovr when v(hov)=1.183 rise=1
  set s_hovr = $&hovr
  meas dc aenr when v(aen)=1.0 rise=1
  set s_aenr = $&aenr
  meas dc aenf when v(aen)=0.9 rise=1
  set s_aenf = $&aenf
  alterparam iov=30u
  reset
  run
  meas dc hsovf when v(ovlo)=2.4 rise=1
  set s_hsovf = $&hsovf
  echo "RESULT thresholds corner=lo panel_uv_rise=$s_uvr panel_uv_fall=$s_uvf hs_uv_on=$s_hsuvr hs_uv_off=$s_hsuvf hs_ov_off=$s_hsovr hs_ov_on=$s_hsovf halo_ov_rise=$s_hovr aux_on=$s_aenr aux_off=$s_aenf"
  alterparam kt=1
  alterparam kb=1
  alterparam iuv=21u
  alterparam iov=0
  reset
  run
  meas dc hsuvr when v(uvlo)=2.5 rise=1
  set s_hsuvr = $&hsuvr
  alterparam iuv=0
  reset
  run
  meas dc uvr when v(efen)=1.2 rise=1
  set s_uvr = $&uvr
  meas dc uvf when v(efen)=1.1 rise=1
  set s_uvf = $&uvf
  meas dc hsuvf when v(uvlo)=2.5 rise=1
  set s_hsuvf = $&hsuvf
  meas dc hsovr when v(ovlo)=2.5 rise=1
  set s_hsovr = $&hsovr
  meas dc hovr when v(hov)=1.2 rise=1
  set s_hovr = $&hovr
  meas dc aenr when v(aen)=1.263 rise=1
  set s_aenr = $&aenr
  meas dc aenf when v(aen)=0.913 rise=1
  set s_aenf = $&aenf
  alterparam iov=21u
  reset
  run
  meas dc hsovf when v(ovlo)=2.5 rise=1
  set s_hsovf = $&hsovf
  echo "RESULT thresholds corner=typ panel_uv_rise=$s_uvr panel_uv_fall=$s_uvf hs_uv_on=$s_hsuvr hs_uv_off=$s_hsuvf hs_ov_off=$s_hsovr hs_ov_on=$s_hsovf halo_ov_rise=$s_hovr aux_on=$s_aenr aux_off=$s_aenf"
  alterparam kt=1.01
  alterparam kb=0.99
  alterparam iuv=30u
  alterparam iov=0
  reset
  run
  meas dc hsuvr when v(uvlo)=2.55 rise=1
  set s_hsuvr = $&hsuvr
  alterparam iuv=0
  reset
  run
  meas dc uvr when v(efen)=1.23 rise=1
  set s_uvr = $&uvr
  meas dc uvf when v(efen)=1.13 rise=1
  set s_uvf = $&uvf
  meas dc hsuvf when v(uvlo)=2.55 rise=1
  set s_hsuvf = $&hsuvf
  meas dc hsovr when v(ovlo)=2.6 rise=1
  set s_hsovr = $&hsovr
  meas dc hovr when v(hov)=1.223 rise=1
  set s_hovr = $&hovr
  meas dc aenr when v(aen)=1.365 rise=1
  set s_aenr = $&aenr
  meas dc aenf when v(aen)=0.865 rise=1
  set s_aenf = $&aenf
  alterparam iov=12u
  reset
  run
  meas dc hsovf when v(ovlo)=2.6 rise=1
  set s_hsovf = $&hsovf
  echo "RESULT thresholds corner=hi panel_uv_rise=$s_uvr panel_uv_fall=$s_uvf hs_uv_on=$s_hsuvr hs_uv_off=$s_hsuvf hs_ov_off=$s_hsovr hs_ov_on=$s_hsovf halo_ov_rise=$s_hovr aux_on=$s_aenr aux_off=$s_aenf"
  quit
.endc
.end
